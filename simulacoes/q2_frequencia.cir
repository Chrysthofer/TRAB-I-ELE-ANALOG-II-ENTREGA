* Questao 2, item (d): resposta em frequencia
* projeto = 1 -> capacitores do metodo das constantes de tempo de curto-circuito (8,73 uF; 6,92 uF)
* projeto = 2 -> capacitores multiplicados por 0,911 para fL = 20 Hz (7,95 uF; 6,30 uF)
.param Cac1={if(projeto==1, 8.73u, 7.95u)} Cac2={if(projeto==1, 6.92u, 6.30u)}
.step param projeto list 1 2
VI vi 0 AC 1
VP vp 0 20
VN vn 0 -25
RS vi x 1k
CC1 x e {Cac1}
RE vp e 10k
Q1 c 0 e QP
* Capacitancias do modelo de pequenos sinais (base = terra): C_pi entre emissor e base, C_mu entre coletor e base
CPI e 0 10p
CMU c 0 1p
RC c vn 6.5k
CC2 c vo {Cac2}
RL vo 0 5k
* beta = 100; VA infinito (padrao); IS escolhida para VEB = 0,7 V na corrente de polarizacao (IC = 1,91 mA)
.model QP PNP(BF=100 IS=3.37f)
.ac dec 200 0.1 10G
.meas ac Amed FIND mag(V(vo)) AT 10k
.meas ac Vo10k FIND V(vo) AT 10k
.meas ac fL WHEN mag(V(vo))=Amed/sqrt(2) RISE=1
.meas ac fH WHEN mag(V(vo))=Amed/sqrt(2) FALL=1
.end
